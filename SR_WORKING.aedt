# Ansys Electronics Desktop project, version 2024.2
materials:
  vacuum: permittivity=1

design HFSSDesign1 (HFSS, HFSS Terminal Network, model units mm)
geometry:
  coordinate_system RelativeCS1 = origin=(-0.9mm, 2mm, 0mm) x=(1mm, 0mm, 0mm) y=(0mm, 1mm, 0mm)
  coordinate_system RelativeCS2 = origin=(-1mm, 1.4mm, 0mm) x=(1mm, 0mm, 0mm) y=(0mm, 1mm, 0mm)
  Polyline4 = polyline(z=0mm, xy in mm: (-0.58, -0.02) (0.54598705, 0.19671844) (-0.45947263, -0.35452066), AngularArc from point 0 over 3 centre=(0mm, 0mm, 0mm) angle=-324.32181deg plane=XY) in RelativeCS2
  Polyline6 = polyline(z=0mm, xy in mm: (-0.58, -0.02) (0.04, -0.02) (0.04, 0.04) (-0.5, 0.04)) in RelativeCS2
  Polyline7 = polyline(z=0mm, xy in mm: (-0.5, 0.04) (0.4818077, 0.13950391) (-0.40127796, -0.30095847), AngularArc from point 0 over 3 centre=(0mm, 0mm, 0mm) angle=-318.55618deg plane=XY) in RelativeCS2
  Polyline8 = polyline((-0.45947263mm, -0.35452066mm, 0mm) (-0.40127796mm, -0.30095847mm, 0mm)) in RelativeCS2
  Polyline6.unite(Polyline4, Polyline7, Polyline8)
  Polyline6.cover_lines()
