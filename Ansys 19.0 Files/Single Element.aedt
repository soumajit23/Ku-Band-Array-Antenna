# Ansys Electronics Desktop project, version 2018.0
materials:
  vacuum: permittivity=1
  Rogers RT/duroid 5880 (tm): permittivity=2.2 dielectric_loss_tangent=0.0009

design HFSSDesign1 (HFSS, DrivenModal, model units mm)
variables:
  Hs = 1.6mm
  Ls = 12mm
  Ws = 15mm
  Wp = 12.2158mm
  Lp = 8.8871mm
  Lf = 1.8mm
  Wf = 1.13mm
geometry:
  substrate [Rogers RT/duroid 5880 (tm)] = box(corner=(-Ws/2, 0mm, 0mm), size=(Ws, Ls, Hs))
  coordinate_system ObjectCS1 = object of substrate: Origin=middle of substrate.edge(6 of 12) xAxis{xDirection=1 yDirection=0 zDirection=0} yAxis{xDirection=0 yDirection=1 zDirection=0}
  Patch1 = rectangle(corner=(-Wp/2, Lf, Hs), x_size=Wp, y_size=Lp) in ObjectCS1
  Feed = rectangle(corner=(-Wf/2, 0mm, Hs), x_size=Wf, y_size=Lf)
  Port = rectangle(corner=(-Wf/2, 0mm, Hs), z_size=-Hs, x_size=Wf)
  Patch1.unite(Feed)
  Gnd = rectangle(corner=(-7.5mm, 12mm, 0mm), x_size=15mm, y_size=-12mm)
  RadiatingSurface [vacuum] = region(absolute_offset=10mm on all sides)
boundaries and excitations:
  PerfE1: Perfect E Objects=Patch1
  Gnd: Perfect E Objects=Gnd
  Open1: Radiation Objects=RadiatingSurface
  1: Lumped Port Objects=Port Modes{Mode1{IntLine{middle of Port.edge(z opposite corner) -> middle of Port.edge(z at corner)} CharImp=Zpi RenormImp=50ohm}} Impedance=50ohm
setups:
  Setup1: HfssDriven Frequency=10GHz MaxDeltaS=0.02 MaximumPasses=20 MinimumPasses=1 MinimumConvergedPasses=1 PercentRefinement=30 BasisOrder=1 PortAccuracy=2 VariablesForDerivatives(Lf, Lp, Wf, Wp) VariableFlagsForDerivatives(1, 1, 1, 1)
    sweep Sweep: 5GHz to 15GHz, 401 points; Type=Discrete SaveFields
source amplitudes:
  1:1: 1W 0deg
radiation setups:
  3D: Infinite Sphere Theta=0deg..180deg step 2deg Phi=-180deg..180deg step 2deg
  Elevation: Infinite Sphere Theta=-180deg..180deg step 1deg Phi=0deg..90deg step 90deg
  Azimuth: Infinite Sphere Theta=90deg..90deg step 0deg Phi=-180deg..180deg step 1deg
  Infinite Sphere1: Infinite Sphere Theta=0deg..360deg step 5deg Phi=0deg..0deg step 0deg
reports:
  S Parameter Plot 1: dB(S(1,1)) vs Freq on Setup1 : Sweep; markers m1 at 10.3GHz, MY1 at y=-10
  Gain Plot 1: dB(GainTotal) vs Theta on Setup1 : Sweep, Infinite Sphere1 [Phi=all Freq=10GHz Wp=all Lp=all Lf=all Wf=all]; markers m1 at 360deg
  VSWR Plot 1: abs(VSWR(1)) vs Freq on Setup1 : Sweep; markers m1 at 10.3GHz
  Gain Plot 2: dB(GainTotal) vs Phi, Theta on Setup1 : Sweep, 3D [Freq=10GHz Lp=8.8871mm Wf=1.13mm]
