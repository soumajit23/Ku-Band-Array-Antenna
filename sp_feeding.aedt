# Ansys Electronics Desktop project, version 2024.2
materials:
  vacuum: permittivity=1

design HFSSDesign1 (HFSS, HFSS Terminal Network, model units mm)
variables:
  Ls = 70mm
  r1 = 5.6mm
  r2 = 4.9mm
  r4 = 4.2mm
  r3 = 3.9mm
  W1 = 1.46mm
  L1 = 5.2mm
  L2 = 15.4mm
  W2 = 0.2mm
geometry:
  Box1 [vacuum] = box(corner=(-Ls/2, -Ls/2, 0mm), size=(Ls, Ls, -0.2mm))
  Circle1 = circle(normal=Z, centre=(0mm, 0mm, 0mm), radius=r1)
  Rectangle1 = rectangle(corner=(-8mm, 0mm, 0mm), x_size=16mm, y_size=8mm)
  Rectangle2 = rectangle(corner=(0mm, 8mm, 0mm), x_size=8mm, y_size=-14mm)
  Circle1.subtract(Rectangle1, Rectangle2)
  Circle2 = circle(normal=Z, centre=(0mm, 0mm, 0mm), radius=r2, segments=2000)
  Rectangle3 = rectangle(corner=(0mm, -5.6mm, 0mm), x_size=8mm, y_size=11.6mm)
  Rectangle4 = rectangle(corner=(0mm, -5.6mm, 0mm), x_size=-8mm, y_size=5.6mm)
  Circle2.subtract(Rectangle3, Rectangle4)
  Circle3 = circle(normal=Z, centre=(0mm, 0mm, 0mm), radius=r4, segments=2000)
  Rectangle5 = rectangle(corner=(0mm, -5.6mm, 0mm), x_size=-6mm, y_size=11.6mm)
  Rectangle6 = rectangle(corner=(-5.6mm, 0mm, 0mm), x_size=11.6mm, y_size=-6mm)
  Circle3.subtract(Rectangle5, Rectangle6)
  Circle4 = circle(normal=Z, centre=(0mm, 0mm, 0mm), radius=r3)
  Circle4_1 = Circle4.copy()
  Circle1.subtract(Circle4_1)
  Circle4_2 = Circle4.copy()
  Circle2.subtract(Circle4_2)
  Circle3.subtract(Circle4)
  Rectangle7 = rectangle(corner=(-W1/2, -0.4mm, 0mm), x_size=W1, y_size=-L1)
  Rectangle8 = rectangle(corner=(-W2/2, -3.9mm, 0mm), x_size=W2, y_size=-L2-1.7mm)
  Rectangle9 = rectangle(corner=(-3.9mm, -W2/2, 0mm), x_size=-L2-1.7mm, y_size=W2)
  Rectangle10 = rectangle(corner=(-W2/2, 3.9mm, 0mm), x_size=W2, y_size=L2+1.7mm)
  Rectangle11 = rectangle(corner=(3.9mm, -W2/2, 0mm), x_size=L2+1.7mm, y_size=W2)
  Circle5 = circle(normal=Z, centre=(0mm, 0mm, 0mm), radius=r1)
  Rectangle12 = rectangle(corner=(-8mm, 0mm, 0mm), x_size=16mm, y_size=8mm)
  Rectangle13 = rectangle(corner=(0mm, 8mm, 0mm), x_size=8mm, y_size=-14mm)
  Circle5.subtract(Rectangle12, Rectangle13)
  Circle6 = circle(normal=Z, centre=(0mm, 0mm, 0mm), radius=r3)
  Circle4_3 = Circle6.copy()
  Circle5.subtract(Circle4_3)
  Circle6.delete()
  Circle7 = circle(normal=Z, centre=(0mm, 0mm, 0mm), radius=r1)
  Rectangle14 = rectangle(corner=(-8mm, 0mm, 0mm), x_size=16mm, y_size=8mm)
  Rectangle15 = rectangle(corner=(0mm, 8mm, 0mm), x_size=8mm, y_size=-14mm)
  Circle7.subtract(Rectangle14, Rectangle15)
  Circle8 = circle(normal=Z, centre=(0mm, 0mm, 0mm), radius=r3)
  Circle4_4 = Circle8.copy()
  Circle7.subtract(Circle4_4)
  Circle8.delete()
  Circle9 = circle(normal=Z, centre=(0mm, 0mm, 0mm), radius=5.6mm)
  Circle10 = circle(normal=Z, centre=(0mm, 0mm, 0mm), radius=6mm)
  Circle10.subtract(Circle9)
  Rectangle7.subtract(Circle10)
